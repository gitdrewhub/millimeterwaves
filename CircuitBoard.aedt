# Ansys Electronics Desktop project, version 2016.2
materials:
  vacuum: permittivity=1
  PTFE: permittivity=2.1 conductivity=1e-16 dielectric_loss_tangent=0.00015
  copper: permeability=0.999991 conductivity=58000000
  brass: conductivity=15000000
  Rogers RO3003 (tm): permittivity=3 dielectric_loss_tangent=0.0013
  solder: conductivity=7000000
  epoxy_Kevlar_xy: permittivity=3.6
  silicon: permittivity=11.9
  air: permittivity=1.0006 permeability=1.0000004
  perfect conductor: conductivity=1e+30

design HFSSDesign1 (HFSS, DrivenModal, model units mm)
geometry:
  Rectangle1 [Rogers RO3003 (tm)] = rectangle(corner=(-20mm, -10mm, 0mm), x_size=40mm, y_size=20mm)
  Rectangle1.thicken(-1.5748mm)
  Rectangle10..Rectangle15 [copper] = imported_body(C:\Users\aluc2\Documents\Ansoft\SOT23-6.aedtresults\FC_SOT23_6.sm3)
  Si_Die [silicon] = imported_body(C:\Users\aluc2\Documents\Ansoft\SOT23-6.aedtresults\FC_SOT23_6.sm3)
  Encapsulation [epoxy_Kevlar_xy] = imported_body(C:\Users\aluc2\Documents\Ansoft\SOT23-6.aedtresults\FC_SOT23_6.sm3)
  CutPin1Indent1_Detach1, CutPin1Indent1_Detach2, CutPin1Indent1_Detach3 = imported_body(C:\Users\aluc2\Documents\Ansoft\SOT23-6.aedtresults\FC_SOT23_6.sm3)
  Sphere1..Sphere12 [solder] = imported_body(C:\Users\aluc2\Documents\Ansoft\SOT23-6.aedtresults\FC_SOT23_6.sm3)
  Rectangle16 = rectangle(corner=(1mm, -1.2mm, 0mm), x_size=0.5mm, y_size=2.4mm)
  Rectangle16.thicken(0.02mm)
  Rectangle17 [copper] = rectangle(corner=(1.5mm, -0.0635mm, 0mm), x_size=15.04mm, y_size=0.127mm)
  CutPin1Indent1_Detach1.unite(CutPin1Indent1_Detach2, Rectangle16, CutPin1Indent1_Detach3)
  Rectangle17.thicken(0.02mm)
  Rectangle17.unite(CutPin1Indent1_Detach1)
  GroundPlane [copper] = rectangle(corner=(20mm, -10mm, -1.5748mm), x_size=-40mm, y_size=20mm)
  GroundPlane.thicken(0.03556mm)
  Rectangle19 [copper] = rectangle(corner=(-20mm, -4.7625mm, -1.61036mm), x_size=4.5753mm, y_size=1.016mm)
  Rectangle19.thicken(-0.11684mm)
  Rectangle19_1 [copper] = Rectangle19.duplicate_mirror(point=(-16mm, 0mm, 0mm), normal=(0mm, -1mm, 0mm))
  Rectangle19_2 [copper] = Rectangle19.duplicate_mirror(point=(0mm, 4mm, 0mm), normal=(1mm, 0mm, 0mm))
  Rectangle19_1_1 [copper] = Rectangle19_1.duplicate_mirror(point=(0mm, 4mm, 0mm), normal=(1mm, 0mm, 0mm))
  Rectangle20 [air] = rectangle(corner=(-29.6995mm, -10mm, 0mm), x_size=59.399mm, y_size=20mm)
  Rectangle20.thicken(20mm, both sides)
  Rectangle21 = rectangle(corner=(0.5mm, 1.15mm, 0.95mm), x_size=-0.3mm, y_size=-2.3mm)
  Rectangle21_1 = Rectangle21.duplicate_mirror(point=(0mm, 0.3mm, 0mm), normal=(-1mm, 0mm, 0mm))
  STTailsPoint [copper] = imported_body(C:\Users\aluc2\Documents\Ansoft\Model Files\SMA_50Ohm_mk2.STEP)
  STPinPoint = imported_body(C:\Users\aluc2\Documents\Ansoft\Model Files\SMA_50Ohm_mk2.STEP)
  [STTailsPoint, STPinPoint].rotate(axis=Z, angle=-90deg)
  [STTailsPoint, STPinPoint].move(17.92mm, 0mm, 6.74mm)
  STPinPoint1 = imported_body(C:\Users\aluc2\Documents\Ansoft\Model Files\SMA_50Ohm_mk2.STEP)
  STPinPoint1.rotate(axis=Z, angle=-90deg)
  STPinPoint1.move(17.92mm, 0mm, 6.74mm)
  Rectangle17.subtract(STPinPoint1)
  Rectangle17_1 [copper] = Rectangle17.duplicate_mirror(point=(0mm, 3mm, 0mm), normal=(-1mm, 0mm, 0mm))
  STTailsPoint_ObjectFromFace1 [PTFE] = object_from(?.face(#4182))
  STTailsPoint_ObjectFromFace1.sweep_along_vector((-6.09mm, 0mm, 0mm))
  STTailsPoint_ObjectFromFace1_1 [PTFE] = STTailsPoint_ObjectFromFace1.duplicate_mirror(point=(0mm, 4mm, 0mm), normal=(-1mm, 0mm, 0mm))
  STTailsPoint_1 [copper] = STTailsPoint.duplicate_mirror(point=(0mm, 4mm, 0mm), normal=(-1mm, 0mm, 0mm))
  STPinPoint_1 [copper] = STPinPoint.duplicate_mirror(point=(0mm, 4mm, 0mm), normal=(-1mm, 0mm, 0mm))
  STPinPoint.delete()
  Rectangle22 = rectangle(corner=(0.2mm, -1.15mm, 0.95mm), x_size=-0.4mm, y_size=2.3mm)
  STPinPoint2 = imported_body(C:\Users\aluc2\Documents\Ansoft\Model Files\SMA_50Ohm_mk2.STEP)
  STPinPoint2.rotate(axis=Z, angle=-90deg)
  STPinPoint2.move(17.92mm, 0mm, 6.74mm)
  STPinPoint_2 = STPinPoint2.duplicate_mirror(point=(0mm, 4mm, 0mm), normal=(-1mm, 0mm, 0mm))
  STPinPoint2.delete()
  STPinPoint_1.move(-6.2mm, 0mm, 0mm)
  STPinPoint3 = imported_body(C:\Users\aluc2\Documents\Ansoft\Model Files\SMA_50Ohm_mk2.STEP)
  STPinPoint3.rotate(axis=Z, angle=-90deg)
  STPinPoint3.move(17.92mm, 0mm, 6.74mm)
  STPinPoint_3 = STPinPoint3.duplicate_mirror(point=(0mm, 4mm, 0mm), normal=(-1mm, 0mm, 0mm))
  STPinPoint3.delete()
  STPinPoint_2.move(-3.412076mm, 0mm, 0mm)
  STPinPoint_1.unite(STPinPoint_2, STPinPoint_3)
  STPinPoint_1_1 [copper] = STPinPoint_1.duplicate_mirror(point=(0mm, 3mm, 0mm), normal=(1mm, 0mm, 0mm))
  Circle1 = circle(normal=X, centre=(27.59mm, 0mm, 0.38mm), radius=2.315mm)
  Circle1_1 = Circle1.duplicate_mirror(point=(0mm, 4mm, 0mm), normal=(-1mm, 0mm, 0mm))
  Rectangle23 = rectangle(corner=(-2.5mm, 10mm, 0.02mm), y_size=-20mm, z_size=(-1.5948-0.03556) mm)
  Rectangle23_1 = Rectangle23.duplicate_mirror(point=(0mm, 2.2mm, 0mm), normal=(1mm, 0mm, 0mm))
boundaries and excitations:
  LumpRLC1: Lumped RLC Objects=Rectangle22 CurrentLine{Rectangle22.edge(x opposite corner) at 0.413 along -> Rectangle22.edge(x at corner) at 0.587 along} Resistance=100ohm
  3: Lumped Port Faces=Rectangle21_1.face Modes{Mode1{IntLine{Rectangle21_1.edge(2 of 4) at 0.326 along -> Rectangle21_1.edge(4 of 4) at 0.652 along} CharImp=Zpi RenormImp=50ohm}} FullResistance=50ohm FullReactance=0ohm
  4: Lumped Port Faces=Rectangle21.face(at (0.35, 0, 0.95)) Modes{Mode1{IntLine{Rectangle21.edge(x opposite corner) at 0.717 along -> Rectangle21.edge(x at corner) at 0.304 along} CharImp=Zpi RenormImp=50ohm}} FullResistance=50ohm FullReactance=0ohm
  1: Lumped Port Objects=Circle1 Modes{Mode1{IntLine{centre of Circle1.face(at (27.59, 0, 0.38)) -> Circle1.edge(1 of 1) at 0.25 along} CharImp=Zpi RenormImp=50ohm}} FullResistance=50ohm FullReactance=0ohm
  2: Lumped Port Objects=Circle1_1 Modes{Mode1{IntLine{centre of Circle1_1.face -> Circle1_1.edge(1 of 1) at 0.25 along} CharImp=Zpi RenormImp=50ohm}} FullResistance=50ohm FullReactance=0ohm
  5: Lumped Port Objects=Rectangle23 Modes{Mode1{IntLine{Rectangle23.face(at (-2.5, 0, -0.79518)) -> Rectangle23.face(at (-2.5, 0, -0.79518))} CharImp=Zpi RenormImp=50ohm}} FullResistance=50ohm FullReactance=0ohm
  6: Lumped Port Objects=Rectangle23_1 Modes{Mode1{IntLine{middle of Rectangle23_1.edge(3 of 4) -> Rectangle23_1.face} CharImp=Zpi RenormImp=50ohm}} FullResistance=50ohm FullReactance=0ohm
setups:
  Setup1: HfssDriven Frequency=30GHz MaxDeltaS=0.01 MaximumPasses=30 MinimumPasses=1 MinimumConvergedPasses=1 PercentRefinement=30 BasisOrder=1 PortAccuracy=2
    sweep Sweep: 25GHz to 100GHz step 1GHz; Type=Interpolating InterpTolerance=2 InterpMaxSolns=200 InterpUsePortImped=false PassivityErrorTolerance=0.0001
source amplitudes:
  3:1: 1W 0deg
  4:1, 1:1, 2:1, 5:1, 6:1: 0W 0deg
reports:
  XY Plot 1: dB(S(1,1)), dB(S(1,2)), dB(S(2,1)), dB(S(2,2)) vs Freq on Setup1 : Sweep
  XY Plot 6: dB(S(3,3)), dB(S(3,4)), dB(S(4,3)), dB(S(4,4)) vs Freq on Setup1 : Sweep
  XY Plot 7: dB(S(1,1)), dB(S(1,3)), dB(S(3,1)), dB(S(3,3)) vs Freq on Setup1 : Sweep
  XY Plot 8: re(S(1,1)), re(S(1,2)), re(S(2,1)), re(S(2,2)) vs Freq on Setup1 : Sweep
  XY Plot 9: im(S(1,1)), im(S(1,2)), im(S(2,1)), im(S(2,2)) vs Freq on Setup1 : Sweep
  XY Plot 10: re(S(1,1)), re(S(1,3)), re(S(3,1)), re(S(3,3)) vs Freq on Setup1 : Sweep
  XY Plot 11: im(S(1,1)), im(S(1,3)), im(S(3,1)), im(S(3,3)) vs Freq on Setup1 : Sweep
  XY Plot 12: re(S(1,1)), re(S(1,2)), re(S(1,3)), re(S(1,4)), re(S(1,5)), re(S(1,6)), re(S(2,1)), re(S(2,2)), re(S(2,3)), re(S(2,4)), re(S(2,5)), re(S(2,6)), re(S(3,1)), re(S(3,2)), re(S(3,3)), re(S(3,4)), re(S(3,5)), re(S(3,6)), re(S(4,1)), re(S(4,2)), re(S(4,3)), re(S(4,4)), re(S(4,5)), re(S(4,6)), re(S(5,1)), re(S(5,2)), re(S(5,3)), re(S(5,4)), re(S(5,5)), re(S(5,6)), re(S(6,1)), re(S(6,2)), re(S(6,3)), re(S(6,4)), re(S(6,5)), re(S(6,6)) vs Freq on Setup1 : Sweep
  XY Plot 13: im(S(1,1)), im(S(1,2)), im(S(1,3)), im(S(1,4)), im(S(1,5)), im(S(1,6)), im(S(2,1)), im(S(2,2)), im(S(2,3)), im(S(2,4)), im(S(2,5)), im(S(2,6)), im(S(3,1)), im(S(3,2)), im(S(3,3)), im(S(3,4)), im(S(3,5)), im(S(3,6)), im(S(4,1)), im(S(4,2)), im(S(4,3)), im(S(4,4)), im(S(4,5)), im(S(4,6)), im(S(5,1)), im(S(5,2)), im(S(5,3)), im(S(5,4)), im(S(5,5)), im(S(5,6)), im(S(6,1)), im(S(6,2)), im(S(6,3)), im(S(6,4)), im(S(6,5)), im(S(6,6)) vs Freq on Setup1 : Sweep
